* 五级 CMOS 反相器环形振荡器。自己写的网表，只用 ngspice 内置的 level 1 MOS 模型，不含任何工艺库。
.model nm nmos level=1 vto=0.5 kp=200u lambda=0.05
.model pm pmos level=1 vto=-0.5 kp=80u lambda=0.05
vdd vdd 0 1.8
.subckt inv a y vdd
mp y a vdd vdd pm w=2u l=0.18u
mn y a 0 0 nm w=1u l=0.18u
c1 y 0 20f
.ends
x1 n1 n2 vdd inv
x2 n2 n3 vdd inv
x3 n3 n4 vdd inv
x4 n4 n5 vdd inv
x5 n5 n1 vdd inv
.ic v(n1)=0 v(n2)=1.8 v(n3)=0 v(n4)=1.8 v(n5)=0.9
.options interp
.tran 5p 1.5u uic
.end
